// acf.scs
simulator lang=spectre

// 1. Analog solver options (Standard convergence settings)
simulatorOptions options reltol=1e-3 vabstol=1e-6 iabstol=1e-12

// 2. Transient Analysis setup
// Defines the max run time for the analog solver. Set this to match your SV testbench!
my_tran_sim tran stop=2m step=1ns
