// amscf.scs
simulator lang=spectre

include "comparator.scs"
include "acf.scs"

// The AMSD Bridge Block
amsd {
    ie vsup=0.65
    portmap subckt=comparator autobus=yes

    // Use the cell-based approach but without the braces
    config inst=tb_top.genblk1.dut_spice_inst.dut_spice use=spice
    //config inst=tb_top.dut_spice use=spice
    //config inst=tb_top.dut_spice use=spice
}
